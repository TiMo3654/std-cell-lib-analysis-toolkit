simulator lang=spectre
global 0 vdd!
include "/mnt/data/pdk/XKIT/xt018/cadence/v10_0/spectre/v10_0_4/lp5mos/config.scs" section=default
include "/mnt/data/pdk/XKIT/xt018/cadence/v10_0/spectre/v10_0_4/lp5mos/param.scs" section=3s
include "/mnt/data/pdk/XKIT/xt018/cadence/v10_0/spectre/v10_0_4/lp5mos/bip.scs" section=tm
include "/mnt/data/pdk/XKIT/xt018/cadence/v10_0/spectre/v10_0_4/lp5mos/cap.scs" section=tm
include "/mnt/data/pdk/XKIT/xt018/cadence/v10_0/spectre/v10_0_4/lp5mos/dio.scs" section=tm
include "/mnt/data/pdk/XKIT/xt018/cadence/v10_0/spectre/v10_0_4/lp5mos/mos.scs" section=tm
include "/mnt/data/pdk/XKIT/xt018/cadence/v10_0/spectre/v10_0_4/lp5mos/res.scs" section=tm
include "./../../data/xt018_ff_subcircuits.scs"

I0 (C D Q QN RN 0 vdd!) DFRRHDX1
V0 (D0 0) vsource type=pulse val0=0.0 val1=1.8 delay=1e-08 rise=1e-12 fall=1e-12 width=1, period=2
V1 (D 0) vsource dc=1.8 type=dc
V2 (RN 0) vsource dc=1.8 type=dc
V3 (C 0) vsource type=pulse val0=0.0 val1=1.8 delay=2e-09 rise=1e-12 fall=1e-12 width=5e-08, period=1e-07
V4 (vdd! 0) vsource dc=1.8 type=dc
C0 (Q 0) capacitor c=1e-15
C1 (QN 0) capacitor c=1e-15

simulatorOptions options psfversion="1.4.0" reltol=1e-3 vabstol=1e-6 \
    iabstol=1e-12 temp=125 tnom=27 homotopy=all limit=delta scalem=1.0 \
    scale=1.0 compatible=spice2 gmin=1e-12 rforce=1 \
    redefinedparams=warning maxnotes=5 maxwarns=5 digits=5 cols=80 \
    pivrel=1e-3 sensfile="../psf/sens.output" checklimitdest=psf
tran tran stop=5e-07 errpreset=conservative write="spectre.ic" \
    writefinal="spectre.fc" annotate=status maxiters=5
finalTimeOP info what=oppoint where=rawfile
modelParameter info what=models where=rawfile
element info what=inst where=rawfile
outputParameter info what=output where=rawfile
designParamVals info what=parameters where=rawfile
primitives info what=primitives where=rawfile
subckts info what=subckts where=rawfile
saveOptions options save=allpub
